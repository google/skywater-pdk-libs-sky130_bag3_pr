simulator lang=spectre

subckt ideal_balun d c p n
    K0 d 0 p c transformer n1=2
    K1 d 0 c n transformer n1=2
ends ideal_balun
